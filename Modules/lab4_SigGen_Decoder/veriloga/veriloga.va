// VerilogA for ece4740, lab4_SigGen_Decoder, veriloga

`include "constants.vams"
`include "disciplines.vams"

module lab4_SigGen_Decoder(A, B, C);
    // Declare inputs and outputs
    output A, B, C;

    voltage EN;
    voltage A, B, C;

    // Clock period for test cases
    localparam cp = 192n;  // Shorter period for rapid testing

    // Constants for clock periods and signal transitions
    parameter real clk_period = cp from (0:inf);
    parameter real trise = 20p from [0:inf];
    parameter real tfall = 20p from [0:inf];

    // Constants for voltage signal bounds
    real v_high = 1.2;
    real v_low = 0.0;
    real v_thre = 0.75 * v_high;

    // Internal variables to hold the current state of input signals
    real a0_cur = v_low, a1_cur = v_low, a2_cur = v_low;

    // TestCount Integer
    integer curInputCount = 0;

    analog begin
        @(initial_step) begin
            curInputCount = 0;
            a0_cur = v_low; a1_cur = v_low; a2_cur = v_low;
        end

        @(timer(1n, clk_period)) begin
            // Update signals based on test case
            a2_cur = ((curInputCount / 4) % 2)? v_high: v_low;
            a1_cur = ((curInputCount / 2) % 2)? v_high: v_low;
            a0_cur = (curInputCount % 2)? v_high: v_low;

            curInputCount = curInputCount + 1;
            // Reset test count after last case to restart the sequence
            if (curInputCount >= 8) begin
                curInputCount = 0;
            end
        end
        V(A) <+ transition(a2_cur, 0, trise, tfall);
        V(B) <+ transition(a1_cur, 0, trise, tfall);
        V(C) <+ transition(a0_cur, 0, trise, tfall);
    end

endmodule
